* 8 data bits + even-parity bit; error=1 indicates odd total parity
* Vector order: d0 d1 d2 d3 d4 d5 d6 d7 parity
.model nch  nmos level = 54

+version = 4.0             binunit = 1               paramchk= 1               mobmod  = 0
+capmod  = 2               igcmod  = 1               igbmod  = 1               geomod  = 1
+diomod  = 1               rdsmod  = 0               rbodymod= 1               rgatemod= 1
+permod  = 1               acnqsmod= 0               trnqsmod= 0

+tnom    = 27              toxe    = 6.541023354447807e-10        toxp    = 4e-010          toxm    = 6.5e-010
+dtox    = 2.5e-010        epsrox  = 3.9             wint    = 5e-009          lint    = 1.35e-009
+ll      = 0               wl      = 0               lln     = 1               wln     = 1
+lw      = 0               ww      = 0               lwn     = 1               wwn     = 1
+lwl     = 0               wwl     = 0               xpart   = 0               toxref  = 6.5e-010         xl      = -9e-9
+dlcig   = 1.35e-009

+vth0    = 0.34837755787461644          k1      = 0.2             k2      = 0               k3      = 0
+k3b     = 0               w0      = 2.5e-006        dvt0    = 1               dvt1    = 2
+dvt2    = 0               dvt0w   = 0               dvt1w   = 0               dvt2w   = 0
+dsub    = 0.078           minv    = 0.05            voffl   = 0               dvtp0   = 1e-011
+dvtp1   = 0.1             lpe0    = 0               lpeb    = 0               xj      = 7.083322794715733e-09
+ngate   = 1e+023          ndep    = 1.2663331993040667e+19        nsd     = 2e+020          phin    = 0
+cdsc    = 0               cdscb   = 0               cdscd   = 0               cit     = 0
+voff    = -0.13           nfactor = 2.3             eta0    = 0.0045          etab    = 0
+vfb     = -1.058          u0      = 0.019198694099666673          ua      = -5e-010         ub      = 1.7e-018
+uc      = 0               vsat    = 200000          a0      = 1               ags     = 0
+a1      = 0               a2      = 1               b0      = 0               b1      = 0
+keta    = 0.04            dwg     = 0               dwb     = 0               pclm    = 0.06
+pdiblc1 = 0.001           pdiblc2 = 0.001           pdiblcb = -0.005          drout   = 0.5
+pvag    = 1e-020          delta   = 0.01            pscbe1  = 2.0e+009        pscbe2  = 1e-007
+fprout  = 0.2             pdits   = 0.01            pditsd  = 0.23            pditsl  = 2300000
+rsh     = 5               rdsw    = 60              rsw     = 30              rdw     = 30
+rdswmin = 0               rdwmin  = 0               rswmin  = 0               prwg    = 0
+prwb    = 0               wr      = 1               alpha0  = 0.074           alpha1  = 0.005
+beta0   = 30              agidl   = 0.0002          bgidl   = 2.1e+009        cgidl   = 0.0002
+egidl   = 0.8             aigbacc = 0.012           bigbacc = 0.0028          cigbacc = 0.002
+nigbacc = 1               aigbinv = 0.014           bigbinv = 0.004           cigbinv = 0.004
+eigbinv = 1.1             nigbinv = 3               aigc    = 0.0213          bigc    = 0.0025889
+cigc    = 0.002           aigsd   = 0.0213          bigsd   = 0.0025889       cigsd   = 0.002
+nigc    = 1               poxedge = 1               pigcd   = 1               ntox    = 1
+xrcrg1  = 12              xrcrg2  = 5

+cgso    = 7e-011          cgdo    = 7e-011          cgbo    = 0               cgdl    = 7.5e-013
+cgsl    = 7.5e-013        clc     = 1e-007          cle     = 0.6             cf      = 1.1e-010
+ckappas = 0.6             ckappad = 0.6             vfbcv   = -1              acde    = 1
+moin    = 15              noff    = 1               voffcv  = 0

+kt1     = -0.154          kt1l    = 0               kt2     = 0.022           ute     = -1.1
+ua1     = 1e-009          ub1     = -1e-018         uc1     = -5.6e-011       prt     = 0
+at      = 33000

+fnoimod = 1               tnoimod = 0               noia    = 6.25e+041       noib    = 3.125e+026
+noic    = 8.75e+009       em      = 41000000        af      = 1               ef      = 1
+kf      = 0               tnoia   = 1.5             tnoib   = 3.5             ntnoi   = 1

+jss     = 1.2e-006        jsws    = 2.4e-013        jswgs   = 2.4e-013        njs     = 1
+ijthsfwd= 0.1             ijthsrev= 0.1             bvs     = 10              xjbvs   = 1
+jsd     = 1.2e-006        jswd    = 2.4e-013        jswgd   = 2.4e-013        xjbvd   = 1
+pbs     = 1               cjs     = 0.0018          mjs     = 0.5             pbsws   = 1
+cjsws   = 1.2e-010        mjsws   = 0.33            cjswgs  = 2.1e-010        cjd     = 0.0018
+cjswd   = 1.2e-010        mjswd   = 0.33            pbswgd  = 1               cjswgd  = 2.1e-010
+mjswgd  = 0.33            tpb     = 0               tcj     = 0               tpbsw   = 0
+tcjsw   = 0               tpbswg  = 0               tcjswg  = 0               xtis    = 3

+dmcg    = 0               dmci    = 0               dmdg    = 0               dmcgt   = 0
+dwj     = 0               xgw     = 0               xgl     = 0

+rshg    = 0.4             gbmin   = 1e-010          rbpb    = 5               rbpd    = 15
+rbps    = 15              rbdb    = 15              rbsb    = 15              ngcon   = 1
.model pch  pmos level = 54

+version = 4.0             binunit = 1               paramchk= 1               mobmod  = 0
+capmod  = 2               igcmod  = 1               igbmod  = 1               geomod  = 1
+diomod  = 1               rdsmod  = 0               rbodymod= 1               rgatemod= 1
+permod  = 1               acnqsmod= 0               trnqsmod= 0

+tnom    = 27              toxe    = 7.076911204416038e-10        toxp    = 4e-010          toxm    = 6.7e-010
+dtox    = 2.7e-010        epsrox  = 3.9             wint    = 5e-009          lint    = 1.35e-009
+ll      = 0               wl      = 0               lln     = 1               wln     = 1
+lw      = 0               ww      = 0               lwn     = 1               wwn     = 1
+lwl     = 0               wwl     = 0               xpart   = 0               toxref  = 6.7e-010         xl      = -9e-9
+dlcig   = 1.35e-009

+vth0    = -0.2627328670636468        k1      = 0.2             k2      = -0.01           k3      = 0
+k3b     = 0               w0      = 2.5e-006        dvt0    = 1               dvt1    = 2
+dvt2    = -0.032          dvt0w   = 0               dvt1w   = 0               dvt2w   = 0
+dsub    = 0.1             minv    = 0.05            voffl   = 0               dvtp0   = 1e-011
+dvtp1   = 0.05            lpe0    = 0               lpeb    = 0               xj      = 6.508842532722783e-09
+ngate   = 1e+023          ndep    = 4.600722825775482e+18        nsd     = 2e+020          phin    = 0
+cdsc    = 0               cdscb   = 0               cdscd   = 0               cit     = 0
+voff    = -0.13           nfactor = 2.3             eta0    = 0.0037          etab    = 0
+vfb     = -1.058          u0      = 0.0023683562987313585          ua      = -5e-010         ub      = 1.6e-018
+uc      = 0               vsat    = 78000           a0      = 1               ags     = 1e-020
+a1      = 0               a2      = 1               b0      = 0               b1      = 0
+keta    = -0.047          dwg     = 0               dwb     = 0               pclm    = 0.1
+pdiblc1 = 0.001           pdiblc2 = 0.001           pdiblcb = 3.4e-008        drout   = 0.6
+pvag    = 1e-020          delta   = 0.01            pscbe1  = 2e+009          pscbe2  = 9.58e-007
+fprout  = 0.2             pdits   = 0.08            pditsd  = 0.23            pditsl  = 2300000
+rsh     = 5               rdsw    = 60              rsw     = 30              rdw     = 30
+rdswmin = 0               rdwmin  = 0               rswmin  = 0               prwg    = 0
+prwb    = 0               wr      = 1               alpha0  = 0.074           alpha1  = 0.005
+beta0   = 30              agidl   = 0.0002          bgidl   = 2.1e+009        cgidl   = 0.0002
+egidl   = 0.8             aigbacc = 0.012           bigbacc = 0.0028          cigbacc = 0.002
+nigbacc = 1               aigbinv = 0.014           bigbinv = 0.004           cigbinv = 0.004
+eigbinv = 1.1             nigbinv = 3               aigc    = 0.012731        bigc    = 0.00115
+cigc    = 0.0008          aigsd   = 0.012731        bigsd   = 0.00115         cigsd   = 0.0008
+nigc    = 1               poxedge = 1               pigcd   = 1               ntox    = 1
+xrcrg1  = 12              xrcrg2  = 5

+cgso    = 7e-011          cgdo    = 7e-011          cgbo    = 0               cgdl    = 3e-011
+cgsl    = 3e-011          clc     = 1e-007          cle     = 0.6             cf      = 1.1e-010
+ckappas = 0.6             ckappad = 0.6             vfbcv   = -1              acde    = 1
+moin    = 15              noff    = 1               voffcv  = 0

+kt1     = -0.14           kt1l    = 0               kt2     = 0.022           ute     = -1.1
+ua1     = 1e-009          ub1     = -1e-018         uc1     = -5.6e-011       prt     = 0
+at      = 33000

+fnoimod = 1               tnoimod = 0               noia    = 6.25e+041       noib    = 3.125e+026
+noic    = 8.75e+009       em      = 41000000        af      = 1               ef      = 1
+kf      = 0               tnoia   = 1.5             tnoib   = 3.5             ntnoi   = 1

+jss     = 2e-007          jsws    = 4e-013          jswgs   = 4e-013          njs     = 1
+ijthsfwd= 0.1             ijthsrev= 0.1             bvs     = 10              xjbvs   = 1
+jsd     = 2e-007          jswd    = 4e-013          jswgd   = 4e-013          xjbvd   = 1
+pbs     = 1               cjs     = 0.0015          mjs     = 0.5             pbsws   = 1
+cjsws   = 9.4e-011        mjsws   = 0.33            cjswgs  = 2e-010          cjd     = 0.0015
+cjswd   = 9.4e-011        mjswd   = 0.33            pbswgd  = 1               cjswgd  = 2e-010
+mjswgd  = 0.33            tpb     = 0               tcj     = 0               tpbsw   = 0
+tcjsw   = 0               tpbswg  = 0               tcjswg  = 0               xtis    = 3

+dmcg    = 0               dmdg    = 0               dmcgt   = 0               xgw     = 0
+xgl     = 0

+rshg    = 0.1             gbmin   = 1e-012          rbpb    = 50              rbpd    = 50
+rbps    = 50              rbdb    = 50              rbsb    = 50              ngcon   = 1
.options gmin=1e-18 abstol=1e-18 reltol=1e-6 vntol=1e-9
.temp 87.773033312979067
vsupply vdd 0 DC 0.84220826646157854
ms0_0_n1_mp1 s0_0_n1 d0 vdd vdd pch W=2.1999999999999998e-08 L=2.1999999999999998e-08 AD=9.6799999999999995e-16 AS=9.6799999999999995e-16
ms0_0_n1_mp2 s0_0_n1 d1 vdd vdd pch W=2.1999999999999998e-08 L=2.1999999999999998e-08 AD=9.6799999999999995e-16 AS=9.6799999999999995e-16
ms0_0_n1_mn1 s0_0_n1 d0 s0_0_n1_stack 0 nch W=2.1999999999999998e-08 L=2.1999999999999998e-08 AD=9.6799999999999995e-16 AS=9.6799999999999995e-16
ms0_0_n1_mn2 s0_0_n1_stack d1 0 0 nch W=2.1999999999999998e-08 L=2.1999999999999998e-08 AD=9.6799999999999995e-16 AS=9.6799999999999995e-16
ms0_0_n2_mp1 s0_0_n2 d0 vdd vdd pch W=2.1999999999999998e-08 L=2.1999999999999998e-08 AD=9.6799999999999995e-16 AS=9.6799999999999995e-16
ms0_0_n2_mp2 s0_0_n2 s0_0_n1 vdd vdd pch W=2.1999999999999998e-08 L=2.1999999999999998e-08 AD=9.6799999999999995e-16 AS=9.6799999999999995e-16
ms0_0_n2_mn1 s0_0_n2 d0 s0_0_n2_stack 0 nch W=2.1999999999999998e-08 L=2.1999999999999998e-08 AD=9.6799999999999995e-16 AS=9.6799999999999995e-16
ms0_0_n2_mn2 s0_0_n2_stack s0_0_n1 0 0 nch W=2.1999999999999998e-08 L=2.1999999999999998e-08 AD=9.6799999999999995e-16 AS=9.6799999999999995e-16
ms0_0_n3_mp1 s0_0_n3 d1 vdd vdd pch W=2.1999999999999998e-08 L=2.1999999999999998e-08 AD=9.6799999999999995e-16 AS=9.6799999999999995e-16
ms0_0_n3_mp2 s0_0_n3 s0_0_n1 vdd vdd pch W=2.1999999999999998e-08 L=2.1999999999999998e-08 AD=9.6799999999999995e-16 AS=9.6799999999999995e-16
ms0_0_n3_mn1 s0_0_n3 d1 s0_0_n3_stack 0 nch W=2.1999999999999998e-08 L=2.1999999999999998e-08 AD=9.6799999999999995e-16 AS=9.6799999999999995e-16
ms0_0_n3_mn2 s0_0_n3_stack s0_0_n1 0 0 nch W=2.1999999999999998e-08 L=2.1999999999999998e-08 AD=9.6799999999999995e-16 AS=9.6799999999999995e-16
ms0_0_mp1 s0_0 s0_0_n2 vdd vdd pch W=2.1999999999999998e-08 L=2.1999999999999998e-08 AD=9.6799999999999995e-16 AS=9.6799999999999995e-16
ms0_0_mp2 s0_0 s0_0_n3 vdd vdd pch W=2.1999999999999998e-08 L=2.1999999999999998e-08 AD=9.6799999999999995e-16 AS=9.6799999999999995e-16
ms0_0_mn1 s0_0 s0_0_n2 s0_0_stack 0 nch W=2.1999999999999998e-08 L=2.1999999999999998e-08 AD=9.6799999999999995e-16 AS=9.6799999999999995e-16
ms0_0_mn2 s0_0_stack s0_0_n3 0 0 nch W=2.1999999999999998e-08 L=2.1999999999999998e-08 AD=9.6799999999999995e-16 AS=9.6799999999999995e-16
ms0_1_n1_mp1 s0_1_n1 d2 vdd vdd pch W=2.1999999999999998e-08 L=2.1999999999999998e-08 AD=9.6799999999999995e-16 AS=9.6799999999999995e-16
ms0_1_n1_mp2 s0_1_n1 d3 vdd vdd pch W=2.1999999999999998e-08 L=2.1999999999999998e-08 AD=9.6799999999999995e-16 AS=9.6799999999999995e-16
ms0_1_n1_mn1 s0_1_n1 d2 s0_1_n1_stack 0 nch W=2.1999999999999998e-08 L=2.1999999999999998e-08 AD=9.6799999999999995e-16 AS=9.6799999999999995e-16
ms0_1_n1_mn2 s0_1_n1_stack d3 0 0 nch W=2.1999999999999998e-08 L=2.1999999999999998e-08 AD=9.6799999999999995e-16 AS=9.6799999999999995e-16
ms0_1_n2_mp1 s0_1_n2 d2 vdd vdd pch W=2.1999999999999998e-08 L=2.1999999999999998e-08 AD=9.6799999999999995e-16 AS=9.6799999999999995e-16
ms0_1_n2_mp2 s0_1_n2 s0_1_n1 vdd vdd pch W=2.1999999999999998e-08 L=2.1999999999999998e-08 AD=9.6799999999999995e-16 AS=9.6799999999999995e-16
ms0_1_n2_mn1 s0_1_n2 d2 s0_1_n2_stack 0 nch W=2.1999999999999998e-08 L=2.1999999999999998e-08 AD=9.6799999999999995e-16 AS=9.6799999999999995e-16
ms0_1_n2_mn2 s0_1_n2_stack s0_1_n1 0 0 nch W=2.1999999999999998e-08 L=2.1999999999999998e-08 AD=9.6799999999999995e-16 AS=9.6799999999999995e-16
ms0_1_n3_mp1 s0_1_n3 d3 vdd vdd pch W=2.1999999999999998e-08 L=2.1999999999999998e-08 AD=9.6799999999999995e-16 AS=9.6799999999999995e-16
ms0_1_n3_mp2 s0_1_n3 s0_1_n1 vdd vdd pch W=2.1999999999999998e-08 L=2.1999999999999998e-08 AD=9.6799999999999995e-16 AS=9.6799999999999995e-16
ms0_1_n3_mn1 s0_1_n3 d3 s0_1_n3_stack 0 nch W=2.1999999999999998e-08 L=2.1999999999999998e-08 AD=9.6799999999999995e-16 AS=9.6799999999999995e-16
ms0_1_n3_mn2 s0_1_n3_stack s0_1_n1 0 0 nch W=2.1999999999999998e-08 L=2.1999999999999998e-08 AD=9.6799999999999995e-16 AS=9.6799999999999995e-16
ms0_1_mp1 s0_1 s0_1_n2 vdd vdd pch W=2.1999999999999998e-08 L=2.1999999999999998e-08 AD=9.6799999999999995e-16 AS=9.6799999999999995e-16
ms0_1_mp2 s0_1 s0_1_n3 vdd vdd pch W=2.1999999999999998e-08 L=2.1999999999999998e-08 AD=9.6799999999999995e-16 AS=9.6799999999999995e-16
ms0_1_mn1 s0_1 s0_1_n2 s0_1_stack 0 nch W=2.1999999999999998e-08 L=2.1999999999999998e-08 AD=9.6799999999999995e-16 AS=9.6799999999999995e-16
ms0_1_mn2 s0_1_stack s0_1_n3 0 0 nch W=2.1999999999999998e-08 L=2.1999999999999998e-08 AD=9.6799999999999995e-16 AS=9.6799999999999995e-16
ms0_2_n1_mp1 s0_2_n1 d4 vdd vdd pch W=2.1999999999999998e-08 L=2.1999999999999998e-08 AD=9.6799999999999995e-16 AS=9.6799999999999995e-16
ms0_2_n1_mp2 s0_2_n1 d5 vdd vdd pch W=2.1999999999999998e-08 L=2.1999999999999998e-08 AD=9.6799999999999995e-16 AS=9.6799999999999995e-16
ms0_2_n1_mn1 s0_2_n1 d4 s0_2_n1_stack 0 nch W=2.1999999999999998e-08 L=2.1999999999999998e-08 AD=9.6799999999999995e-16 AS=9.6799999999999995e-16
ms0_2_n1_mn2 s0_2_n1_stack d5 0 0 nch W=2.1999999999999998e-08 L=2.1999999999999998e-08 AD=9.6799999999999995e-16 AS=9.6799999999999995e-16
ms0_2_n2_mp1 s0_2_n2 d4 vdd vdd pch W=2.1999999999999998e-08 L=2.1999999999999998e-08 AD=9.6799999999999995e-16 AS=9.6799999999999995e-16
ms0_2_n2_mp2 s0_2_n2 s0_2_n1 vdd vdd pch W=2.1999999999999998e-08 L=2.1999999999999998e-08 AD=9.6799999999999995e-16 AS=9.6799999999999995e-16
ms0_2_n2_mn1 s0_2_n2 d4 s0_2_n2_stack 0 nch W=2.1999999999999998e-08 L=2.1999999999999998e-08 AD=9.6799999999999995e-16 AS=9.6799999999999995e-16
ms0_2_n2_mn2 s0_2_n2_stack s0_2_n1 0 0 nch W=2.1999999999999998e-08 L=2.1999999999999998e-08 AD=9.6799999999999995e-16 AS=9.6799999999999995e-16
ms0_2_n3_mp1 s0_2_n3 d5 vdd vdd pch W=2.1999999999999998e-08 L=2.1999999999999998e-08 AD=9.6799999999999995e-16 AS=9.6799999999999995e-16
ms0_2_n3_mp2 s0_2_n3 s0_2_n1 vdd vdd pch W=2.1999999999999998e-08 L=2.1999999999999998e-08 AD=9.6799999999999995e-16 AS=9.6799999999999995e-16
ms0_2_n3_mn1 s0_2_n3 d5 s0_2_n3_stack 0 nch W=2.1999999999999998e-08 L=2.1999999999999998e-08 AD=9.6799999999999995e-16 AS=9.6799999999999995e-16
ms0_2_n3_mn2 s0_2_n3_stack s0_2_n1 0 0 nch W=2.1999999999999998e-08 L=2.1999999999999998e-08 AD=9.6799999999999995e-16 AS=9.6799999999999995e-16
ms0_2_mp1 s0_2 s0_2_n2 vdd vdd pch W=2.1999999999999998e-08 L=2.1999999999999998e-08 AD=9.6799999999999995e-16 AS=9.6799999999999995e-16
ms0_2_mp2 s0_2 s0_2_n3 vdd vdd pch W=2.1999999999999998e-08 L=2.1999999999999998e-08 AD=9.6799999999999995e-16 AS=9.6799999999999995e-16
ms0_2_mn1 s0_2 s0_2_n2 s0_2_stack 0 nch W=2.1999999999999998e-08 L=2.1999999999999998e-08 AD=9.6799999999999995e-16 AS=9.6799999999999995e-16
ms0_2_mn2 s0_2_stack s0_2_n3 0 0 nch W=2.1999999999999998e-08 L=2.1999999999999998e-08 AD=9.6799999999999995e-16 AS=9.6799999999999995e-16
ms0_3_n1_mp1 s0_3_n1 d6 vdd vdd pch W=2.1999999999999998e-08 L=2.1999999999999998e-08 AD=9.6799999999999995e-16 AS=9.6799999999999995e-16
ms0_3_n1_mp2 s0_3_n1 d7 vdd vdd pch W=2.1999999999999998e-08 L=2.1999999999999998e-08 AD=9.6799999999999995e-16 AS=9.6799999999999995e-16
ms0_3_n1_mn1 s0_3_n1 d6 s0_3_n1_stack 0 nch W=2.1999999999999998e-08 L=2.1999999999999998e-08 AD=9.6799999999999995e-16 AS=9.6799999999999995e-16
ms0_3_n1_mn2 s0_3_n1_stack d7 0 0 nch W=2.1999999999999998e-08 L=2.1999999999999998e-08 AD=9.6799999999999995e-16 AS=9.6799999999999995e-16
ms0_3_n2_mp1 s0_3_n2 d6 vdd vdd pch W=2.1999999999999998e-08 L=2.1999999999999998e-08 AD=9.6799999999999995e-16 AS=9.6799999999999995e-16
ms0_3_n2_mp2 s0_3_n2 s0_3_n1 vdd vdd pch W=2.1999999999999998e-08 L=2.1999999999999998e-08 AD=9.6799999999999995e-16 AS=9.6799999999999995e-16
ms0_3_n2_mn1 s0_3_n2 d6 s0_3_n2_stack 0 nch W=2.1999999999999998e-08 L=2.1999999999999998e-08 AD=9.6799999999999995e-16 AS=9.6799999999999995e-16
ms0_3_n2_mn2 s0_3_n2_stack s0_3_n1 0 0 nch W=2.1999999999999998e-08 L=2.1999999999999998e-08 AD=9.6799999999999995e-16 AS=9.6799999999999995e-16
ms0_3_n3_mp1 s0_3_n3 d7 vdd vdd pch W=2.1999999999999998e-08 L=2.1999999999999998e-08 AD=9.6799999999999995e-16 AS=9.6799999999999995e-16
ms0_3_n3_mp2 s0_3_n3 s0_3_n1 vdd vdd pch W=2.1999999999999998e-08 L=2.1999999999999998e-08 AD=9.6799999999999995e-16 AS=9.6799999999999995e-16
ms0_3_n3_mn1 s0_3_n3 d7 s0_3_n3_stack 0 nch W=2.1999999999999998e-08 L=2.1999999999999998e-08 AD=9.6799999999999995e-16 AS=9.6799999999999995e-16
ms0_3_n3_mn2 s0_3_n3_stack s0_3_n1 0 0 nch W=2.1999999999999998e-08 L=2.1999999999999998e-08 AD=9.6799999999999995e-16 AS=9.6799999999999995e-16
ms0_3_mp1 s0_3 s0_3_n2 vdd vdd pch W=2.1999999999999998e-08 L=2.1999999999999998e-08 AD=9.6799999999999995e-16 AS=9.6799999999999995e-16
ms0_3_mp2 s0_3 s0_3_n3 vdd vdd pch W=2.1999999999999998e-08 L=2.1999999999999998e-08 AD=9.6799999999999995e-16 AS=9.6799999999999995e-16
ms0_3_mn1 s0_3 s0_3_n2 s0_3_stack 0 nch W=2.1999999999999998e-08 L=2.1999999999999998e-08 AD=9.6799999999999995e-16 AS=9.6799999999999995e-16
ms0_3_mn2 s0_3_stack s0_3_n3 0 0 nch W=2.1999999999999998e-08 L=2.1999999999999998e-08 AD=9.6799999999999995e-16 AS=9.6799999999999995e-16
ms1_0_n1_mp1 s1_0_n1 s0_0 vdd vdd pch W=2.1999999999999998e-08 L=2.1999999999999998e-08 AD=9.6799999999999995e-16 AS=9.6799999999999995e-16
ms1_0_n1_mp2 s1_0_n1 s0_1 vdd vdd pch W=2.1999999999999998e-08 L=2.1999999999999998e-08 AD=9.6799999999999995e-16 AS=9.6799999999999995e-16
ms1_0_n1_mn1 s1_0_n1 s0_0 s1_0_n1_stack 0 nch W=2.1999999999999998e-08 L=2.1999999999999998e-08 AD=9.6799999999999995e-16 AS=9.6799999999999995e-16
ms1_0_n1_mn2 s1_0_n1_stack s0_1 0 0 nch W=2.1999999999999998e-08 L=2.1999999999999998e-08 AD=9.6799999999999995e-16 AS=9.6799999999999995e-16
ms1_0_n2_mp1 s1_0_n2 s0_0 vdd vdd pch W=2.1999999999999998e-08 L=2.1999999999999998e-08 AD=9.6799999999999995e-16 AS=9.6799999999999995e-16
ms1_0_n2_mp2 s1_0_n2 s1_0_n1 vdd vdd pch W=2.1999999999999998e-08 L=2.1999999999999998e-08 AD=9.6799999999999995e-16 AS=9.6799999999999995e-16
ms1_0_n2_mn1 s1_0_n2 s0_0 s1_0_n2_stack 0 nch W=2.1999999999999998e-08 L=2.1999999999999998e-08 AD=9.6799999999999995e-16 AS=9.6799999999999995e-16
ms1_0_n2_mn2 s1_0_n2_stack s1_0_n1 0 0 nch W=2.1999999999999998e-08 L=2.1999999999999998e-08 AD=9.6799999999999995e-16 AS=9.6799999999999995e-16
ms1_0_n3_mp1 s1_0_n3 s0_1 vdd vdd pch W=2.1999999999999998e-08 L=2.1999999999999998e-08 AD=9.6799999999999995e-16 AS=9.6799999999999995e-16
ms1_0_n3_mp2 s1_0_n3 s1_0_n1 vdd vdd pch W=2.1999999999999998e-08 L=2.1999999999999998e-08 AD=9.6799999999999995e-16 AS=9.6799999999999995e-16
ms1_0_n3_mn1 s1_0_n3 s0_1 s1_0_n3_stack 0 nch W=2.1999999999999998e-08 L=2.1999999999999998e-08 AD=9.6799999999999995e-16 AS=9.6799999999999995e-16
ms1_0_n3_mn2 s1_0_n3_stack s1_0_n1 0 0 nch W=2.1999999999999998e-08 L=2.1999999999999998e-08 AD=9.6799999999999995e-16 AS=9.6799999999999995e-16
ms1_0_mp1 s1_0 s1_0_n2 vdd vdd pch W=2.1999999999999998e-08 L=2.1999999999999998e-08 AD=9.6799999999999995e-16 AS=9.6799999999999995e-16
ms1_0_mp2 s1_0 s1_0_n3 vdd vdd pch W=2.1999999999999998e-08 L=2.1999999999999998e-08 AD=9.6799999999999995e-16 AS=9.6799999999999995e-16
ms1_0_mn1 s1_0 s1_0_n2 s1_0_stack 0 nch W=2.1999999999999998e-08 L=2.1999999999999998e-08 AD=9.6799999999999995e-16 AS=9.6799999999999995e-16
ms1_0_mn2 s1_0_stack s1_0_n3 0 0 nch W=2.1999999999999998e-08 L=2.1999999999999998e-08 AD=9.6799999999999995e-16 AS=9.6799999999999995e-16
ms1_1_n1_mp1 s1_1_n1 s0_2 vdd vdd pch W=2.1999999999999998e-08 L=2.1999999999999998e-08 AD=9.6799999999999995e-16 AS=9.6799999999999995e-16
ms1_1_n1_mp2 s1_1_n1 s0_3 vdd vdd pch W=2.1999999999999998e-08 L=2.1999999999999998e-08 AD=9.6799999999999995e-16 AS=9.6799999999999995e-16
ms1_1_n1_mn1 s1_1_n1 s0_2 s1_1_n1_stack 0 nch W=2.1999999999999998e-08 L=2.1999999999999998e-08 AD=9.6799999999999995e-16 AS=9.6799999999999995e-16
ms1_1_n1_mn2 s1_1_n1_stack s0_3 0 0 nch W=2.1999999999999998e-08 L=2.1999999999999998e-08 AD=9.6799999999999995e-16 AS=9.6799999999999995e-16
ms1_1_n2_mp1 s1_1_n2 s0_2 vdd vdd pch W=2.1999999999999998e-08 L=2.1999999999999998e-08 AD=9.6799999999999995e-16 AS=9.6799999999999995e-16
ms1_1_n2_mp2 s1_1_n2 s1_1_n1 vdd vdd pch W=2.1999999999999998e-08 L=2.1999999999999998e-08 AD=9.6799999999999995e-16 AS=9.6799999999999995e-16
ms1_1_n2_mn1 s1_1_n2 s0_2 s1_1_n2_stack 0 nch W=2.1999999999999998e-08 L=2.1999999999999998e-08 AD=9.6799999999999995e-16 AS=9.6799999999999995e-16
ms1_1_n2_mn2 s1_1_n2_stack s1_1_n1 0 0 nch W=2.1999999999999998e-08 L=2.1999999999999998e-08 AD=9.6799999999999995e-16 AS=9.6799999999999995e-16
ms1_1_n3_mp1 s1_1_n3 s0_3 vdd vdd pch W=2.1999999999999998e-08 L=2.1999999999999998e-08 AD=9.6799999999999995e-16 AS=9.6799999999999995e-16
ms1_1_n3_mp2 s1_1_n3 s1_1_n1 vdd vdd pch W=2.1999999999999998e-08 L=2.1999999999999998e-08 AD=9.6799999999999995e-16 AS=9.6799999999999995e-16
ms1_1_n3_mn1 s1_1_n3 s0_3 s1_1_n3_stack 0 nch W=2.1999999999999998e-08 L=2.1999999999999998e-08 AD=9.6799999999999995e-16 AS=9.6799999999999995e-16
ms1_1_n3_mn2 s1_1_n3_stack s1_1_n1 0 0 nch W=2.1999999999999998e-08 L=2.1999999999999998e-08 AD=9.6799999999999995e-16 AS=9.6799999999999995e-16
ms1_1_mp1 s1_1 s1_1_n2 vdd vdd pch W=2.1999999999999998e-08 L=2.1999999999999998e-08 AD=9.6799999999999995e-16 AS=9.6799999999999995e-16
ms1_1_mp2 s1_1 s1_1_n3 vdd vdd pch W=2.1999999999999998e-08 L=2.1999999999999998e-08 AD=9.6799999999999995e-16 AS=9.6799999999999995e-16
ms1_1_mn1 s1_1 s1_1_n2 s1_1_stack 0 nch W=2.1999999999999998e-08 L=2.1999999999999998e-08 AD=9.6799999999999995e-16 AS=9.6799999999999995e-16
ms1_1_mn2 s1_1_stack s1_1_n3 0 0 nch W=2.1999999999999998e-08 L=2.1999999999999998e-08 AD=9.6799999999999995e-16 AS=9.6799999999999995e-16
ms2_0_n1_mp1 s2_0_n1 s1_0 vdd vdd pch W=2.1999999999999998e-08 L=2.1999999999999998e-08 AD=9.6799999999999995e-16 AS=9.6799999999999995e-16
ms2_0_n1_mp2 s2_0_n1 s1_1 vdd vdd pch W=2.1999999999999998e-08 L=2.1999999999999998e-08 AD=9.6799999999999995e-16 AS=9.6799999999999995e-16
ms2_0_n1_mn1 s2_0_n1 s1_0 s2_0_n1_stack 0 nch W=2.1999999999999998e-08 L=2.1999999999999998e-08 AD=9.6799999999999995e-16 AS=9.6799999999999995e-16
ms2_0_n1_mn2 s2_0_n1_stack s1_1 0 0 nch W=2.1999999999999998e-08 L=2.1999999999999998e-08 AD=9.6799999999999995e-16 AS=9.6799999999999995e-16
ms2_0_n2_mp1 s2_0_n2 s1_0 vdd vdd pch W=2.1999999999999998e-08 L=2.1999999999999998e-08 AD=9.6799999999999995e-16 AS=9.6799999999999995e-16
ms2_0_n2_mp2 s2_0_n2 s2_0_n1 vdd vdd pch W=2.1999999999999998e-08 L=2.1999999999999998e-08 AD=9.6799999999999995e-16 AS=9.6799999999999995e-16
ms2_0_n2_mn1 s2_0_n2 s1_0 s2_0_n2_stack 0 nch W=2.1999999999999998e-08 L=2.1999999999999998e-08 AD=9.6799999999999995e-16 AS=9.6799999999999995e-16
ms2_0_n2_mn2 s2_0_n2_stack s2_0_n1 0 0 nch W=2.1999999999999998e-08 L=2.1999999999999998e-08 AD=9.6799999999999995e-16 AS=9.6799999999999995e-16
ms2_0_n3_mp1 s2_0_n3 s1_1 vdd vdd pch W=2.1999999999999998e-08 L=2.1999999999999998e-08 AD=9.6799999999999995e-16 AS=9.6799999999999995e-16
ms2_0_n3_mp2 s2_0_n3 s2_0_n1 vdd vdd pch W=2.1999999999999998e-08 L=2.1999999999999998e-08 AD=9.6799999999999995e-16 AS=9.6799999999999995e-16
ms2_0_n3_mn1 s2_0_n3 s1_1 s2_0_n3_stack 0 nch W=2.1999999999999998e-08 L=2.1999999999999998e-08 AD=9.6799999999999995e-16 AS=9.6799999999999995e-16
ms2_0_n3_mn2 s2_0_n3_stack s2_0_n1 0 0 nch W=2.1999999999999998e-08 L=2.1999999999999998e-08 AD=9.6799999999999995e-16 AS=9.6799999999999995e-16
ms2_0_mp1 s2_0 s2_0_n2 vdd vdd pch W=2.1999999999999998e-08 L=2.1999999999999998e-08 AD=9.6799999999999995e-16 AS=9.6799999999999995e-16
ms2_0_mp2 s2_0 s2_0_n3 vdd vdd pch W=2.1999999999999998e-08 L=2.1999999999999998e-08 AD=9.6799999999999995e-16 AS=9.6799999999999995e-16
ms2_0_mn1 s2_0 s2_0_n2 s2_0_stack 0 nch W=2.1999999999999998e-08 L=2.1999999999999998e-08 AD=9.6799999999999995e-16 AS=9.6799999999999995e-16
ms2_0_mn2 s2_0_stack s2_0_n3 0 0 nch W=2.1999999999999998e-08 L=2.1999999999999998e-08 AD=9.6799999999999995e-16 AS=9.6799999999999995e-16
merror_n1_mp1 error_n1 s2_0 vdd vdd pch W=2.1999999999999998e-08 L=2.1999999999999998e-08 AD=9.6799999999999995e-16 AS=9.6799999999999995e-16
merror_n1_mp2 error_n1 parity vdd vdd pch W=2.1999999999999998e-08 L=2.1999999999999998e-08 AD=9.6799999999999995e-16 AS=9.6799999999999995e-16
merror_n1_mn1 error_n1 s2_0 error_n1_stack 0 nch W=2.1999999999999998e-08 L=2.1999999999999998e-08 AD=9.6799999999999995e-16 AS=9.6799999999999995e-16
merror_n1_mn2 error_n1_stack parity 0 0 nch W=2.1999999999999998e-08 L=2.1999999999999998e-08 AD=9.6799999999999995e-16 AS=9.6799999999999995e-16
merror_n2_mp1 error_n2 s2_0 vdd vdd pch W=2.1999999999999998e-08 L=2.1999999999999998e-08 AD=9.6799999999999995e-16 AS=9.6799999999999995e-16
merror_n2_mp2 error_n2 error_n1 vdd vdd pch W=2.1999999999999998e-08 L=2.1999999999999998e-08 AD=9.6799999999999995e-16 AS=9.6799999999999995e-16
merror_n2_mn1 error_n2 s2_0 error_n2_stack 0 nch W=2.1999999999999998e-08 L=2.1999999999999998e-08 AD=9.6799999999999995e-16 AS=9.6799999999999995e-16
merror_n2_mn2 error_n2_stack error_n1 0 0 nch W=2.1999999999999998e-08 L=2.1999999999999998e-08 AD=9.6799999999999995e-16 AS=9.6799999999999995e-16
merror_n3_mp1 error_n3 parity vdd vdd pch W=2.1999999999999998e-08 L=2.1999999999999998e-08 AD=9.6799999999999995e-16 AS=9.6799999999999995e-16
merror_n3_mp2 error_n3 error_n1 vdd vdd pch W=2.1999999999999998e-08 L=2.1999999999999998e-08 AD=9.6799999999999995e-16 AS=9.6799999999999995e-16
merror_n3_mn1 error_n3 parity error_n3_stack 0 nch W=2.1999999999999998e-08 L=2.1999999999999998e-08 AD=9.6799999999999995e-16 AS=9.6799999999999995e-16
merror_n3_mn2 error_n3_stack error_n1 0 0 nch W=2.1999999999999998e-08 L=2.1999999999999998e-08 AD=9.6799999999999995e-16 AS=9.6799999999999995e-16
merror_mp1 error error_n2 vdd vdd pch W=2.1999999999999998e-08 L=2.1999999999999998e-08 AD=9.6799999999999995e-16 AS=9.6799999999999995e-16
merror_mp2 error error_n3 vdd vdd pch W=2.1999999999999998e-08 L=2.1999999999999998e-08 AD=9.6799999999999995e-16 AS=9.6799999999999995e-16
merror_mn1 error error_n2 error_stack 0 nch W=2.1999999999999998e-08 L=2.1999999999999998e-08 AD=9.6799999999999995e-16 AS=9.6799999999999995e-16
merror_mn2 error_stack error_n3 0 0 nch W=2.1999999999999998e-08 L=2.1999999999999998e-08 AD=9.6799999999999995e-16 AS=9.6799999999999995e-16
vcode code 0 DC 0
vin_d0 d0 drive_d0 DC 0
bdrive_d0 drive_d0 0 V={0.84220826646157854*(floor((v(code)+0.25)/256)-2*floor((v(code)+0.25)/512))}
vin_d1 d1 drive_d1 DC 0
bdrive_d1 drive_d1 0 V={0.84220826646157854*(floor((v(code)+0.25)/128)-2*floor((v(code)+0.25)/256))}
vin_d2 d2 drive_d2 DC 0
bdrive_d2 drive_d2 0 V={0.84220826646157854*(floor((v(code)+0.25)/64)-2*floor((v(code)+0.25)/128))}
vin_d3 d3 drive_d3 DC 0
bdrive_d3 drive_d3 0 V={0.84220826646157854*(floor((v(code)+0.25)/32)-2*floor((v(code)+0.25)/64))}
vin_d4 d4 drive_d4 DC 0
bdrive_d4 drive_d4 0 V={0.84220826646157854*(floor((v(code)+0.25)/16)-2*floor((v(code)+0.25)/32))}
vin_d5 d5 drive_d5 DC 0
bdrive_d5 drive_d5 0 V={0.84220826646157854*(floor((v(code)+0.25)/8)-2*floor((v(code)+0.25)/16))}
vin_d6 d6 drive_d6 DC 0
bdrive_d6 drive_d6 0 V={0.84220826646157854*(floor((v(code)+0.25)/4)-2*floor((v(code)+0.25)/8))}
vin_d7 d7 drive_d7 DC 0
bdrive_d7 drive_d7 0 V={0.84220826646157854*(floor((v(code)+0.25)/2)-2*floor((v(code)+0.25)/4))}
vin_parity parity drive_parity DC 0
bdrive_parity drive_parity 0 V={0.84220826646157854*(floor((v(code)+0.25)/1)-2*floor((v(code)+0.25)/2))}
.control
set numdgt=17
set num_threads=1
set wr_singlescale
set wr_vecnames
dc vcode 0 511 1
let i_supply = -i(vsupply)
let i_in_d0 = -i(vin_d0)
let i_in_d1 = -i(vin_d1)
let i_in_d2 = -i(vin_d2)
let i_in_d3 = -i(vin_d3)
let i_in_d4 = -i(vin_d4)
let i_in_d5 = -i(vin_d5)
let i_in_d6 = -i(vin_d6)
let i_in_d7 = -i(vin_d7)
let i_in_parity = -i(vin_parity)
let v_s0_0_n1 = v(s0_0_n1)
let v_s0_0_n2 = v(s0_0_n2)
let v_s0_0_n3 = v(s0_0_n3)
let v_s0_0 = v(s0_0)
let v_s0_1_n1 = v(s0_1_n1)
let v_s0_1_n2 = v(s0_1_n2)
let v_s0_1_n3 = v(s0_1_n3)
let v_s0_1 = v(s0_1)
let v_s0_2_n1 = v(s0_2_n1)
let v_s0_2_n2 = v(s0_2_n2)
let v_s0_2_n3 = v(s0_2_n3)
let v_s0_2 = v(s0_2)
let v_s0_3_n1 = v(s0_3_n1)
let v_s0_3_n2 = v(s0_3_n2)
let v_s0_3_n3 = v(s0_3_n3)
let v_s0_3 = v(s0_3)
let v_s1_0_n1 = v(s1_0_n1)
let v_s1_0_n2 = v(s1_0_n2)
let v_s1_0_n3 = v(s1_0_n3)
let v_s1_0 = v(s1_0)
let v_s1_1_n1 = v(s1_1_n1)
let v_s1_1_n2 = v(s1_1_n2)
let v_s1_1_n3 = v(s1_1_n3)
let v_s1_1 = v(s1_1)
let v_s2_0_n1 = v(s2_0_n1)
let v_s2_0_n2 = v(s2_0_n2)
let v_s2_0_n3 = v(s2_0_n3)
let v_s2_0 = v(s2_0)
let v_error_n1 = v(error_n1)
let v_error_n2 = v(error_n2)
let v_error_n3 = v(error_n3)
let v_error = v(error)
let v_input_d0 = v(d0)
let v_input_d1 = v(d1)
let v_input_d2 = v(d2)
let v_input_d3 = v(d3)
let v_input_d4 = v(d4)
let v_input_d5 = v(d5)
let v_input_d6 = v(d6)
let v_input_d7 = v(d7)
let v_input_parity = v(parity)
wrdata measurements.txt i_supply i_in_d0 i_in_d1 i_in_d2 i_in_d3 i_in_d4 i_in_d5 i_in_d6 i_in_d7 i_in_parity v_s0_0_n1 v_s0_0_n2 v_s0_0_n3 v_s0_0 v_s0_1_n1 v_s0_1_n2 v_s0_1_n3 v_s0_1 v_s0_2_n1 v_s0_2_n2 v_s0_2_n3 v_s0_2 v_s0_3_n1 v_s0_3_n2 v_s0_3_n3 v_s0_3 v_s1_0_n1 v_s1_0_n2 v_s1_0_n3 v_s1_0 v_s1_1_n1 v_s1_1_n2 v_s1_1_n3 v_s1_1 v_s2_0_n1 v_s2_0_n2 v_s2_0_n3 v_s2_0 v_error_n1 v_error_n2 v_error_n3 v_error v_input_d0 v_input_d1 v_input_d2 v_input_d3 v_input_d4 v_input_d5 v_input_d6 v_input_d7 v_input_parity
quit
.endc
.end
