* AND2 inputs AB=11, corner 0
.model nch  nmos level = 54

+version = 4.0             binunit = 1               paramchk= 1               mobmod  = 0
+capmod  = 2               igcmod  = 1               igbmod  = 1               geomod  = 1
+diomod  = 1               rdsmod  = 0               rbodymod= 1               rgatemod= 1
+permod  = 1               acnqsmod= 0               trnqsmod= 0

+tnom    = 27              toxe    = 6.541023354447807e-10        toxp    = 4e-010          toxm    = 6.5e-010
+dtox    = 2.5e-010        epsrox  = 3.9             wint    = 5e-009          lint    = 1.35e-009
+ll      = 0               wl      = 0               lln     = 1               wln     = 1
+lw      = 0               ww      = 0               lwn     = 1               wwn     = 1
+lwl     = 0               wwl     = 0               xpart   = 0               toxref  = 6.5e-010         xl      = -9e-9
+dlcig   = 1.35e-009

+vth0    = 0.34837755787461644          k1      = 0.2             k2      = 0               k3      = 0
+k3b     = 0               w0      = 2.5e-006        dvt0    = 1               dvt1    = 2
+dvt2    = 0               dvt0w   = 0               dvt1w   = 0               dvt2w   = 0
+dsub    = 0.078           minv    = 0.05            voffl   = 0               dvtp0   = 1e-011
+dvtp1   = 0.1             lpe0    = 0               lpeb    = 0               xj      = 7.083322794715733e-09
+ngate   = 1e+023          ndep    = 1.2663331993040667e+19        nsd     = 2e+020          phin    = 0
+cdsc    = 0               cdscb   = 0               cdscd   = 0               cit     = 0
+voff    = -0.13           nfactor = 2.3             eta0    = 0.0045          etab    = 0
+vfb     = -1.058          u0      = 0.019198694099666673          ua      = -5e-010         ub      = 1.7e-018
+uc      = 0               vsat    = 200000          a0      = 1               ags     = 0
+a1      = 0               a2      = 1               b0      = 0               b1      = 0
+keta    = 0.04            dwg     = 0               dwb     = 0               pclm    = 0.06
+pdiblc1 = 0.001           pdiblc2 = 0.001           pdiblcb = -0.005          drout   = 0.5
+pvag    = 1e-020          delta   = 0.01            pscbe1  = 2.0e+009        pscbe2  = 1e-007
+fprout  = 0.2             pdits   = 0.01            pditsd  = 0.23            pditsl  = 2300000
+rsh     = 5               rdsw    = 60              rsw     = 30              rdw     = 30
+rdswmin = 0               rdwmin  = 0               rswmin  = 0               prwg    = 0
+prwb    = 0               wr      = 1               alpha0  = 0.074           alpha1  = 0.005
+beta0   = 30              agidl   = 0.0002          bgidl   = 2.1e+009        cgidl   = 0.0002
+egidl   = 0.8             aigbacc = 0.012           bigbacc = 0.0028          cigbacc = 0.002
+nigbacc = 1               aigbinv = 0.014           bigbinv = 0.004           cigbinv = 0.004
+eigbinv = 1.1             nigbinv = 3               aigc    = 0.0213          bigc    = 0.0025889
+cigc    = 0.002           aigsd   = 0.0213          bigsd   = 0.0025889       cigsd   = 0.002
+nigc    = 1               poxedge = 1               pigcd   = 1               ntox    = 1
+xrcrg1  = 12              xrcrg2  = 5

+cgso    = 7e-011          cgdo    = 7e-011          cgbo    = 0               cgdl    = 7.5e-013
+cgsl    = 7.5e-013        clc     = 1e-007          cle     = 0.6             cf      = 1.1e-010
+ckappas = 0.6             ckappad = 0.6             vfbcv   = -1              acde    = 1
+moin    = 15              noff    = 1               voffcv  = 0

+kt1     = -0.154          kt1l    = 0               kt2     = 0.022           ute     = -1.1
+ua1     = 1e-009          ub1     = -1e-018         uc1     = -5.6e-011       prt     = 0
+at      = 33000

+fnoimod = 1               tnoimod = 0               noia    = 6.25e+041       noib    = 3.125e+026
+noic    = 8.75e+009       em      = 41000000        af      = 1               ef      = 1
+kf      = 0               tnoia   = 1.5             tnoib   = 3.5             ntnoi   = 1

+jss     = 1.2e-006        jsws    = 2.4e-013        jswgs   = 2.4e-013        njs     = 1
+ijthsfwd= 0.1             ijthsrev= 0.1             bvs     = 10              xjbvs   = 1
+jsd     = 1.2e-006        jswd    = 2.4e-013        jswgd   = 2.4e-013        xjbvd   = 1
+pbs     = 1               cjs     = 0.0018          mjs     = 0.5             pbsws   = 1
+cjsws   = 1.2e-010        mjsws   = 0.33            cjswgs  = 2.1e-010        cjd     = 0.0018
+cjswd   = 1.2e-010        mjswd   = 0.33            pbswgd  = 1               cjswgd  = 2.1e-010
+mjswgd  = 0.33            tpb     = 0               tcj     = 0               tpbsw   = 0
+tcjsw   = 0               tpbswg  = 0               tcjswg  = 0               xtis    = 3

+dmcg    = 0               dmci    = 0               dmdg    = 0               dmcgt   = 0
+dwj     = 0               xgw     = 0               xgl     = 0

+rshg    = 0.4             gbmin   = 1e-010          rbpb    = 5               rbpd    = 15
+rbps    = 15              rbdb    = 15              rbsb    = 15              ngcon   = 1
.model pch  pmos level = 54

+version = 4.0             binunit = 1               paramchk= 1               mobmod  = 0
+capmod  = 2               igcmod  = 1               igbmod  = 1               geomod  = 1
+diomod  = 1               rdsmod  = 0               rbodymod= 1               rgatemod= 1
+permod  = 1               acnqsmod= 0               trnqsmod= 0

+tnom    = 27              toxe    = 7.076911204416038e-10        toxp    = 4e-010          toxm    = 6.7e-010
+dtox    = 2.7e-010        epsrox  = 3.9             wint    = 5e-009          lint    = 1.35e-009
+ll      = 0               wl      = 0               lln     = 1               wln     = 1
+lw      = 0               ww      = 0               lwn     = 1               wwn     = 1
+lwl     = 0               wwl     = 0               xpart   = 0               toxref  = 6.7e-010         xl      = -9e-9
+dlcig   = 1.35e-009

+vth0    = -0.2627328670636468        k1      = 0.2             k2      = -0.01           k3      = 0
+k3b     = 0               w0      = 2.5e-006        dvt0    = 1               dvt1    = 2
+dvt2    = -0.032          dvt0w   = 0               dvt1w   = 0               dvt2w   = 0
+dsub    = 0.1             minv    = 0.05            voffl   = 0               dvtp0   = 1e-011
+dvtp1   = 0.05            lpe0    = 0               lpeb    = 0               xj      = 6.508842532722783e-09
+ngate   = 1e+023          ndep    = 4.600722825775482e+18        nsd     = 2e+020          phin    = 0
+cdsc    = 0               cdscb   = 0               cdscd   = 0               cit     = 0
+voff    = -0.13           nfactor = 2.3             eta0    = 0.0037          etab    = 0
+vfb     = -1.058          u0      = 0.0023683562987313585          ua      = -5e-010         ub      = 1.6e-018
+uc      = 0               vsat    = 78000           a0      = 1               ags     = 1e-020
+a1      = 0               a2      = 1               b0      = 0               b1      = 0
+keta    = -0.047          dwg     = 0               dwb     = 0               pclm    = 0.1
+pdiblc1 = 0.001           pdiblc2 = 0.001           pdiblcb = 3.4e-008        drout   = 0.6
+pvag    = 1e-020          delta   = 0.01            pscbe1  = 2e+009          pscbe2  = 9.58e-007
+fprout  = 0.2             pdits   = 0.08            pditsd  = 0.23            pditsl  = 2300000
+rsh     = 5               rdsw    = 60              rsw     = 30              rdw     = 30
+rdswmin = 0               rdwmin  = 0               rswmin  = 0               prwg    = 0
+prwb    = 0               wr      = 1               alpha0  = 0.074           alpha1  = 0.005
+beta0   = 30              agidl   = 0.0002          bgidl   = 2.1e+009        cgidl   = 0.0002
+egidl   = 0.8             aigbacc = 0.012           bigbacc = 0.0028          cigbacc = 0.002
+nigbacc = 1               aigbinv = 0.014           bigbinv = 0.004           cigbinv = 0.004
+eigbinv = 1.1             nigbinv = 3               aigc    = 0.012731        bigc    = 0.00115
+cigc    = 0.0008          aigsd   = 0.012731        bigsd   = 0.00115         cigsd   = 0.0008
+nigc    = 1               poxedge = 1               pigcd   = 1               ntox    = 1
+xrcrg1  = 12              xrcrg2  = 5

+cgso    = 7e-011          cgdo    = 7e-011          cgbo    = 0               cgdl    = 3e-011
+cgsl    = 3e-011          clc     = 1e-007          cle     = 0.6             cf      = 1.1e-010
+ckappas = 0.6             ckappad = 0.6             vfbcv   = -1              acde    = 1
+moin    = 15              noff    = 1               voffcv  = 0

+kt1     = -0.14           kt1l    = 0               kt2     = 0.022           ute     = -1.1
+ua1     = 1e-009          ub1     = -1e-018         uc1     = -5.6e-011       prt     = 0
+at      = 33000

+fnoimod = 1               tnoimod = 0               noia    = 6.25e+041       noib    = 3.125e+026
+noic    = 8.75e+009       em      = 41000000        af      = 1               ef      = 1
+kf      = 0               tnoia   = 1.5             tnoib   = 3.5             ntnoi   = 1

+jss     = 2e-007          jsws    = 4e-013          jswgs   = 4e-013          njs     = 1
+ijthsfwd= 0.1             ijthsrev= 0.1             bvs     = 10              xjbvs   = 1
+jsd     = 2e-007          jswd    = 4e-013          jswgd   = 4e-013          xjbvd   = 1
+pbs     = 1               cjs     = 0.0015          mjs     = 0.5             pbsws   = 1
+cjsws   = 9.4e-011        mjsws   = 0.33            cjswgs  = 2e-010          cjd     = 0.0015
+cjswd   = 9.4e-011        mjswd   = 0.33            pbswgd  = 1               cjswgd  = 2e-010
+mjswgd  = 0.33            tpb     = 0               tcj     = 0               tpbsw   = 0
+tcjsw   = 0               tpbswg  = 0               tcjswg  = 0               xtis    = 3

+dmcg    = 0               dmdg    = 0               dmcgt   = 0               xgw     = 0
+xgl     = 0

+rshg    = 0.1             gbmin   = 1e-012          rbpb    = 50              rbpd    = 50
+rbps    = 50              rbdb    = 50              rbsb    = 50              ngcon   = 1

.options gmin=1e-18 abstol=1e-18 reltol=1e-6 vntol=1e-9
.temp 87.77303331297907

vsupply vdd 0 DC 0.8422082664615785
vin_a a 0 DC 0.8422082664615785
vin_b b 0 DC 0.8422082664615785

* M<name> d g s b, each terminal through a 0 V ammeter v<name>_<terminal>
mp1 mp1_d mp1_g mp1_s mp1_b pch W=2.2e-08 L=2.2e-08 AD=9.68e-16 AS=9.68e-16
vmp1_d nand_out mp1_d DC 0
vmp1_g a mp1_g DC 0
vmp1_s vdd mp1_s DC 0
vmp1_b vdd mp1_b DC 0
mp2 mp2_d mp2_g mp2_s mp2_b pch W=2.2e-08 L=2.2e-08 AD=9.68e-16 AS=9.68e-16
vmp2_d nand_out mp2_d DC 0
vmp2_g b mp2_g DC 0
vmp2_s vdd mp2_s DC 0
vmp2_b vdd mp2_b DC 0
mn1 mn1_d mn1_g mn1_s mn1_b nch W=2.2e-08 L=2.2e-08 AD=9.68e-16 AS=9.68e-16
vmn1_d nand_out mn1_d DC 0
vmn1_g a mn1_g DC 0
vmn1_s x mn1_s DC 0
vmn1_b 0 mn1_b DC 0
mn2 mn2_d mn2_g mn2_s mn2_b nch W=2.2e-08 L=2.2e-08 AD=9.68e-16 AS=9.68e-16
vmn2_d x mn2_d DC 0
vmn2_g b mn2_g DC 0
vmn2_s 0 mn2_s DC 0
vmn2_b 0 mn2_b DC 0
mp3 mp3_d mp3_g mp3_s mp3_b pch W=2.2e-08 L=2.2e-08 AD=9.68e-16 AS=9.68e-16
vmp3_d out mp3_d DC 0
vmp3_g nand_out mp3_g DC 0
vmp3_s vdd mp3_s DC 0
vmp3_b vdd mp3_b DC 0
mn3 mn3_d mn3_g mn3_s mn3_b nch W=2.2e-08 L=2.2e-08 AD=9.68e-16 AS=9.68e-16
vmn3_d out mn3_d DC 0
vmn3_g nand_out mn3_g DC 0
vmn3_s 0 mn3_s DC 0
vmn3_b 0 mn3_b DC 0

.control
set numdgt=15
op
let i_supply = -i(vsupply)
let i_in_a = -i(vin_a)
let i_in_b = -i(vin_b)
let v_nand_out = v(nand_out)
let v_out = v(out)
let v_x = v(x)
let mp1_id = i(vmp1_d)
let mp1_ig = i(vmp1_g)
let mp1_is = i(vmp1_s)
let mp1_ib = i(vmp1_b)
let mp2_id = i(vmp2_d)
let mp2_ig = i(vmp2_g)
let mp2_is = i(vmp2_s)
let mp2_ib = i(vmp2_b)
let mn1_id = i(vmn1_d)
let mn1_ig = i(vmn1_g)
let mn1_is = i(vmn1_s)
let mn1_ib = i(vmn1_b)
let mn2_id = i(vmn2_d)
let mn2_ig = i(vmn2_g)
let mn2_is = i(vmn2_s)
let mn2_ib = i(vmn2_b)
let mp3_id = i(vmp3_d)
let mp3_ig = i(vmp3_g)
let mp3_is = i(vmp3_s)
let mp3_ib = i(vmp3_b)
let mn3_id = i(vmn3_d)
let mn3_ig = i(vmn3_g)
let mn3_is = i(vmn3_s)
let mn3_ib = i(vmn3_b)
print i_supply
print i_in_a
print i_in_b
print v_nand_out
print v_out
print v_x
print mp1_id
print mp1_ig
print mp1_is
print mp1_ib
print mp2_id
print mp2_ig
print mp2_is
print mp2_ib
print mn1_id
print mn1_ig
print mn1_is
print mn1_ib
print mn2_id
print mn2_ig
print mn2_is
print mn2_ib
print mp3_id
print mp3_ig
print mp3_is
print mp3_ib
print mn3_id
print mn3_ig
print mn3_is
print mn3_ib
.endc

.end
